*TB_SUN_TR_SKY130NM/TB_NCM
*----------------------------------------------------------------
* Include
*----------------------------------------------------------------
#ifdef Lay
.include ../../../work/lpe/LELO_SVOD_RELOSC_lpe.spi
#else
.include ../../../work/xsch/LELO_SVOD_RELOSC.spice
#endif

*-----------------------------------------------------------------
* OPTIONS
*-----------------------------------------------------------------
.option TNOM=27 GMIN=1e-15 reltol=1e-5 autostop

*-----------------------------------------------------------------
* PARAMETERS
*-----------------------------------------------------------------
.param TRF = 10p

.param AVDD = {vdda}

*-----------------------------------------------------------------
* FORCE
*-----------------------------------------------------------------
VSS  VSS  0     dc 0
VDD  VDD VSS    dc 0.8

*-----------------------------------------------------------------
* DUT
*-----------------------------------------------------------------
.include ../xdut.spi

*----------------------------------------------------------------
* PROBE
*----------------------------------------------------------------
.save all
.OPTIONS SAVECURRENTS

*----------------------------------------------------------------
* NGSPICE control
*----------------------------------------------------------------

.ic v(xdut.bias_ref)=0.39
.ic v(xdut.vgm2)=0.77
.ic v(xdut.vgm3)=0.35

.measure tran t5 WHEN V(xdut.phase1)=0.5 RISE=10
.control
set num_threads=8
set color0=white
set color1=black
unset askquit

tran 1u 100m

write
quit

.endc

.end
