*TB_SUN_TR_SKY130NM/TB_NCM
*----------------------------------------------------------------
* Include
*----------------------------------------------------------------
#ifdef Lay
.include ../../../work/lpe/LELO_BOOST_STEADY_STATE_lpe.spi
#else
.include ../../../work/xsch/LELO_BOOST_STEADY_STATE.spice
#endif
.include ../../../design/1812PS.lib
.include ../../../design/XGL6030.lib
*-----------------------------------------------------------------
* OPTIONS
*-----------------------------------------------------------------
.option TNOM=27 GMIN=1e-15 reltol=1e-5
.OPTIONS savecurrents
*-----------------------------------------------------------------
* FORCE
*-----------------------------------------------------------------
VDD      VDD  0 dc 40m
VC_CLK   VC_CLK 0 dc 0m
R1       OUT    0 10k
*-----------------------------------------------------------------
* DUT
*-----------------------------------------------------------------
.include ../xdut.spi

*----------------------------------------------------------------
* PROBE
*----------------------------------------------------------------
.save i(v.xdut.v1) i(v.xdut.v4) i(v.xdut.v3) i(v.xdut.v5) i(v.xdut.v6) i(v.xdut.v7) i(v.xdut.v8)
.save @r.xdut.r2[i] @r.xdut.r1[i]
.save @m.xdut.xm12.msky130_fd_pr__pfet_01v8[id]
.save @m.xdut.xm5.msky130_fd_pr__nfet_01v8_lvt[id]
.save v(xdut.TEG)
.save v(xdut.VDDC)
.save v(xdut.V1)
.save v(xdut.VHSS1)
.save v(xdut.VLSS)
.save v(xdut.vc)
.save v(xdut.x3.vg1)
.save v(xdut.x3.net3)
.save v(xdut.OFF)

*----------------------------------------------------------------
* NGSPICE control
*----------------------------------------------------------------
.nodeset v(xdut.teg) = 0.02
.nodeset v(xdut.vddc) = 0.8
.nodeset v(xdut.vc) = 0.1

.control
set num_threads=8
set color0=white
set color1=black
unset askquit

tran 1u 200u

write
quit

.endc

.end
