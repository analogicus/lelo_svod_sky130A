*TB_SUN_TR_SKY130NM/TB_NCM
*----------------------------------------------------------------
* Include
*----------------------------------------------------------------
#ifdef Lay
.include ../../../work/lpe/LELO_SVOD_1V8_BOOST_lpe.spi
#else
.include ../../../work/xsch/LELO_SVOD_1V8_BOOST.spice
#endif
.include ../../../design/1812PS.lib
.include ../../../design/XGL6030.lib
*-----------------------------------------------------------------
* OPTIONS
*-----------------------------------------------------------------
.option TNOM=27 GMIN=1e-15 reltol=1e-5

*-----------------------------------------------------------------
* PARAMETERS
*-----------------------------------------------------------------
.param TRF = 10p
+ sky130_fd_pr__pfet_01v8__ajunction_mult = 9.9626e-1
+ sky130_fd_pr__pfet_01v8__pjunction_mult = 1.0009e+0

.param Rout = (1.8*1.8*4*5)/(TEG**2)
*-----------------------------------------------------------------
* FORCE
*-----------------------------------------------------------------
VDD      VDD  0 dc {TEG}
R1       OUT1    0 100k
R2       OUT2   0 {Rout}
*-----------------------------------------------------------------
* DUT
*-----------------------------------------------------------------
.include ../xdut.spi

*----------------------------------------------------------------
* PROBE
*----------------------------------------------------------------
.PROBE p(R1)
.PROBE p(R2)

.save i(v.xdut.v1) i(v.xdut.v2)
.save @m.xdut.x1.xm3.msky130_fd_pr__nfet_01v8_lvt[id]
.save @m.xdut.x1.xm5.msky130_fd_pr__nfet_01v8_lvt[id]
.save v(xdut.TEG)
.save v(xdut.VOUT_0V8)
.save v(xdut.VOUT_1V8)
.save v(xdut.x1.VX)
.save v(xdut.x1.HSS1_1V8)
.save v(xdut.x1.HSS2_1V8)
.save v(xdut.x1.HSS1U_1V8)
.save v(xdut.x1.HSS2U_1V8)
.save v(xdut.x1.HSS1U_0V8)
.save v(xdut.x1.HSS2U_0V8)
.save v(xdut.x1.LSSU_0V8)
.save v(xdut.x1.LSS_1V8)
.save v(xdut.x1.NEN_0V8)
.save v(xdut.x1.EN_1V8)
.save v(xdut.x1.EN_LSS)
.save v(xdut.x1.CLK)
.save v(xdut.osc)
.save v(xdut.EN_START)
.save v(xdut.x1.x8.VREF)
.save v(xdut.x1.x8.VMEAS_0V8)
.save v(xdut.x1.x8.VMEAS_1V8)
.save v(xdut.x1.x8.1V8_L)
.save v(xdut.x1.x6.VC)
.save v(xdut.x1.x6.NHSS2_1v8)
.save v(xdut.x1.x6.SN)
.save v(xdut.x1.x6.SP)
.save v(xdut.x1.x6.net2)
.save v(xdut.x1.x6.x3.net2)
.save v(xdut.x1.x6.x3.net1)
.save v(xdut.x1.x6.x4.net2)
.save v(xdut.x1.x6.x4.net3)
.save v(xdut.x1.x6.UP)
.save v(xdut.x1.x6.DN)
.save v(xdut.x1.x6.net6)
.save v(xdut.x1.x6.CURRENT_ON_P)
.save v(xdut.x1.x6.CURRENT_ON_N)
.save v(xdut.x1.x6.BIASN)
.save v(xdut.x1.x6.BIASP)
.save v(xdut.x1.x6.VX_SAMPL)
.save v(xdut.x1.x6.VOUT_SAMPL)
.save v(xdut.x1.x5.bias_ref)
.save v(xdut.x1.x5.vgm2)
.save v(vss)
.save v(vdd)
.save v(xdut.vdd_1v8)
.save v(xdut.vdd_0v8)

*----------------------------------------------------------------
* NGSPICE control
*----------------------------------------------------------------
.ic v(xdut.x1.x5.bias_ref)=0.32
.ic v(xdut.x1.x5.vgm2)=0.24
.ic v(xdut.x1.x5.net12)=0.11
.ic v(xdut.TEG) = 0.02
.ic v(xdut.VOUT_0V8) = 0.8
.ic v(xdut.VOUT_1V8) = 1.7
.ic v(xdut.x1.x1.vc) = 0.4
.ic v(xdut.x1.x6.vc) = 0.25
.ic v(xdut.x1.x1.x1.net2) = 0.8
.ic v(xdut.x1.HSS1U_1V8) = 0
.ic v(xdut.x1.HSS1U_0V8) = 0
.ic v(xdut.x1.HSS1_1V8) = 0
.ic v(xdut.x1.x1.x1.net1) = 0
.ic v(xdut.x1.x8.vref) = 0.6
.ic v(xdut.x1.x8.x8.v2) = 0.5
.ic v(xdut.x1.x8.x8.net21) = 0.55
.ic v(xdut.x1.x8.x8.net1) = 0.8
.ic v(xdut.x1.x8.x8.net2) = 0.8
.ic v(xdut.x1.x8.x8.net3) = 0.8
.ic v(xdut.x1.x8.x8.net4) = 0.8
.ic v(xdut.x1.x8.x8.net5) = 0.8
.ic v(xdut.x1.x8.x8.net6) = 0.8
.ic v(xdut.x1.x8.x8.net7) = 0.8
.ic v(xdut.x1.x8.x8.net8) = 0.8
.ic v(xdut.x1.x8.x8.net9) = 0.8
.ic v(xdut.x1.x8.x8.net10) = 0.8
.ic v(xdut.x1.x8.x8.net11) = 0.8
.ic v(xdut.x1.x8.x8.net12) = 0.8
.ic v(xdut.x1.x8.x8.net13) = 0.8
.ic v(xdut.x1.x8.x8.net14) = 0.8
.ic v(xdut.x1.x8.x8.net15) = 0.8
.ic v(xdut.x1.x8.x8.net16) = 0.8
.ic v(xdut.x1.x8.x8.net17) = 0.8
.ic v(xdut.x1.x8.x8.net18) = 0.8
.ic v(xdut.x1.x8.x8.net19) = 0.8
.ic v(xdut.x1.x8.x8.net20) = 0.8
.ic v(xdut.x6.x3.net1) = 0.8
.ic v(xdut.x1.x3.net1) = 0.8

.control
set num_threads=8
set color0=white
set color1=black
unset askquit

tran 1u 2000u
write
quit

.endc

.end
