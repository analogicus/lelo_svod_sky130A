*TB_SUN_TR_SKY130NM/TB_NCM
*----------------------------------------------------------------
* Include
*----------------------------------------------------------------
#ifdef Lay
.include ../../../work/lpe/LELO_STARTUP_DETECTOR_TEST_lpe.spi
#else
.include ../../../work/xsch/LELO_STARTUP_DETECTOR_TEST.spice
#endif
.include ../../../design/1812PS.lib
.include ../../../design/XGL6030.lib
*-----------------------------------------------------------------
* OPTIONS
*-----------------------------------------------------------------
.option TNOM=27 GMIN=1e-15 reltol=1e-3 autostop

*-----------------------------------------------------------------
* PARAMETERS
*-----------------------------------------------------------------
.param TRF = 10p

.param AVDD = {vdda}
+ sky130_fd_pr__pfet_01v8__ajunction_mult = 9.9626e-1
+ sky130_fd_pr__pfet_01v8__pjunction_mult = 1.0009e+0

*-----------------------------------------------------------------
* FORCE
*-----------------------------------------------------------------
VSS  VSS  0     dc 0
VDD  VDD  VSS dc 30m

*-----------------------------------------------------------------
* DUT
*-----------------------------------------------------------------
.include ../xdut.spi

*----------------------------------------------------------------
* PROBE
*----------------------------------------------------------------
.save v(xdut.VDD_0V8)
.save v(xdut.out)
.save v(xdut.teg)
.save v(xdut.vref)
.save v(xdut.osc)

*----------------------------------------------------------------
* NGSPICE control
*----------------------------------------------------------------
.measure tran ts WHEN V(xdut.VDD_0V8)=0.5 RISE=1
.control
set num_threads=8
set color0=white
set color1=black
unset askquit

tran 100n 50000u
write
quit

.endc

.end
